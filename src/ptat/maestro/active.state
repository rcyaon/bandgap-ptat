ADE simulation setup
Test personal_ptat_1: personal/ptat/schematic, simulator spectre
  Models: /home/lc2257/SKY130_PDK/sky130_release/libs/sky130_fd_pr_main/../../models/sky130.lib.spice[tt]
  Temperature: 27
Run mode: Single Run, Sweeps and Corners
