ADE simulation setup
Run mode: Single Run, Sweeps and Corners
Tests:
  personal_ptat_1: personal/ptat/schematic, simulator spectre
