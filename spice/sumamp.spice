** sch_path: /foss/designs/sumamp.sch
**.subckt sumamp VDD IPTAT Vref GND
*.ipin IPTAT
*.opin Vref
*.iopin VDD
*.iopin GND
XM3 VSUM IPTAT VDD VDD sky130_fd_pr__pfet_01v8 L=1 W=4 nf=1 ad=1.16 as=1.16 pd=8.58 ps=8.58 nrd=0.0725 nrs=0.0725 sa=0 sb=0 sd=0
+ mult=1 m=1
XR1 VREF_RAW GND GND sky130_fd_pr__res_high_po_0p69 L=1254 mult=1 m=1
XR3 VREF_RAW VSUM GND sky130_fd_pr__res_high_po_0p69 L=1254 mult=1 m=1
x1 VDD IPTAT Vref VREF_RAW Vref GND ota
**.ends

* expanding   symbol:  ota.sym # of pins=6
** sym_path: /foss/designs/ota.sym
** sch_path: /foss/designs/ota.sch
.subckt ota VDD Vb V2 V1 Vout GND
*.iopin VDD
*.iopin GND
*.ipin V2
*.ipin V1
*.opin Vout
*.ipin Vb
XM1 net1 V1 net2 VDD sky130_fd_pr__pfet_01v8 L=1 W=8 nf=2 ad=1.16 as=2.32 pd=8.58 ps=17.16 nrd=0.03625 nrs=0.03625 sa=0 sb=0 sd=0
+ mult=1 m=1
XM3 net1 net1 GND GND sky130_fd_pr__nfet_01v8 L=1 W=4 nf=1 ad=1.16 as=1.16 pd=8.58 ps=8.58 nrd=0.0725 nrs=0.0725 sa=0 sb=0 sd=0
+ mult=1 m=1
XM4 Vout net1 GND GND sky130_fd_pr__nfet_01v8 L=1 W=4 nf=1 ad=1.16 as=1.16 pd=8.58 ps=8.58 nrd=0.0725 nrs=0.0725 sa=0 sb=0 sd=0
+ mult=1 m=1
XM2 Vout V2 net2 VDD sky130_fd_pr__pfet_01v8 L=1 W=8 nf=2 ad=1.16 as=2.32 pd=8.58 ps=17.16 nrd=0.03625 nrs=0.03625 sa=0 sb=0 sd=0
+ mult=1 m=1
XM5 net2 Vb VDD VDD sky130_fd_pr__pfet_01v8 L=2 W=4 nf=1 ad=1.16 as=1.16 pd=8.58 ps=8.58 nrd=0.0725 nrs=0.0725 sa=0 sb=0 sd=0
+ mult=1 m=1
**** begin user architecture code

**** end user architecture code
.ends

.end
