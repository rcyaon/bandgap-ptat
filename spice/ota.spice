** sch_path: /foss/designs/ota.sch
.subckt ota VDD V2 V1 Vout GND
*.PININFO VDD:B GND:B V2:I V1:I Vout:O
XM1 net2 V1 net1 VDD sky130_fd_pr__pfet_01v8 L=2 W=8 nf=2 m=1
XM3 net2 net2 GND GND sky130_fd_pr__nfet_01v8 L=2 W=4 nf=1 m=1
XM4 Vout net2 GND GND sky130_fd_pr__nfet_01v8 L=2 W=4 nf=1 m=1
XM2 Vout V2 net1 VDD sky130_fd_pr__pfet_01v8 L=2 W=8 nf=2 m=1
XM5 net1 net1 VDD VDD sky130_fd_pr__pfet_01v8 L=2 W=4 nf=1 m=1
**** begin user architecture code

**** end user architecture code
.ends
