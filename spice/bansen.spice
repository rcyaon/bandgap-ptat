** sch_path: /foss/designs/bansen.sch
**.subckt bansen VDD GND Vref
*.opin Vref
*.iopin VDD
*.iopin GND
x1 VDD net1 GND ptat
x2 VDD net1 Vref GND sumamp
**.ends

* expanding   symbol:  ptat.sym # of pins=3
** sym_path: /foss/designs/ptat.sym
** sch_path: /foss/designs/ptat.sch
.subckt ptat VDD IPTAT GND
*.iopin VDD
*.iopin GND
*.opin IPTAT
XQ1 net2 net2 net1 sky130_fd_pr__pnp_05v5_W3p40L3p40 m=8 mult=8
XQ2 net2 net2 IPTAT sky130_fd_pr__pnp_05v5_W3p40L3p40 m=1 mult=1
XM1 net1 net1 VDD VDD sky130_fd_pr__pfet_01v8 L=1 W=4 nf=1 ad=1.16 as=1.16 pd=8.58 ps=8.58 nrd=0.0725 nrs=0.0725 sa=0 sb=0 sd=0
+ mult=1 m=1
XM2 IPTAT IPTAT VDD VDD sky130_fd_pr__pfet_01v8 L=1 W=4 nf=1 ad=1.16 as=1.16 pd=8.58 ps=8.58 nrd=0.0725 nrs=0.0725 sa=0 sb=0 sd=0
+ mult=1 m=1
XR1 net2 GND GND sky130_fd_pr__res_high_po_0p69 L=169e-6 mult=1 m=1
x1 VDD net1 IPTAT net1 net2 GND ota
XM3 net2 GND VDD VDD sky130_fd_pr__pfet_01v8 L=4 W=1 nf=1 ad=0.29 as=0.29 pd=2.58 ps=2.58 nrd=0.29 nrs=0.29 sa=0 sb=0 sd=0 mult=1
+ m=1
.ends

* expanding   symbol:  sumamp.sym # of pins=4
** sym_path: /foss/designs/sumamp.sym
** sch_path: /foss/designs/sumamp.sch
.subckt sumamp VDD IPTAT Vref GND
*.ipin IPTAT
*.opin Vref
*.iopin VDD
*.iopin GND
XM3 net2 IPTAT VDD net3 sky130_fd_pr__pfet_01v8 L=1 W=4 nf=1 ad=1.16 as=1.16 pd=8.58 ps=8.58 nrd=0.0725 nrs=0.0725 sa=0 sb=0 sd=0
+ mult=1 m=1
XR1 GND net1 GND sky130_fd_pr__res_high_po_0p69 L=1884e-6 mult=1 m=1
XR3 net1 net2 GND sky130_fd_pr__res_high_po_0p69 L=1884e-6 mult=1 m=1
x1 VDD IPTAT net1 Vref Vref GND ota
**** begin user architecture code
type: subcircuit
**** end user architecture code
.ends

* expanding   symbol:  ota.sym # of pins=6
** sym_path: /foss/designs/ota.sym
** sch_path: /foss/designs/ota.sch
.subckt ota VDD Vb V2 V1 Vout GND
*.iopin VDD
*.iopin GND
*.ipin V2
*.ipin V1
*.opin Vout
*.ipin Vb
XM1 net1 V1 net3 VDD sky130_fd_pr__pfet_01v8 L=1 W=8 nf=2 ad=1.16 as=2.32 pd=8.58 ps=17.16 nrd=0.03625 nrs=0.03625 sa=0 sb=0 sd=0
+ mult=1 m=1
XM3 GND net2 net1 GND sky130_fd_pr__nfet_01v8 L=1 W=4 nf=1 ad=1.16 as=1.16 pd=8.58 ps=8.58 nrd=0.0725 nrs=0.0725 sa=0 sb=0 sd=0
+ mult=1 m=1
XM4 Vout net2 GND GND sky130_fd_pr__nfet_01v8 L=1 W=4 nf=1 ad=1.16 as=1.16 pd=8.58 ps=8.58 nrd=0.0725 nrs=0.0725 sa=0 sb=0 sd=0
+ mult=1 m=1
XM2 net3 V2 Vout VDD sky130_fd_pr__pfet_01v8 L=1 W=8 nf=2 ad=1.16 as=2.32 pd=8.58 ps=17.16 nrd=0.03625 nrs=0.03625 sa=0 sb=0 sd=0
+ mult=1 m=1
XM5 net3 Vb VDD net4 sky130_fd_pr__pfet_01v8 L=2 W=4 nf=1 ad=1.16 as=1.16 pd=8.58 ps=8.58 nrd=0.0725 nrs=0.0725 sa=0 sb=0 sd=0
+ mult=1 m=1
**** begin user architecture code
type: subcircuit
**** end user architecture code
.ends

.end
