** sch_path: /foss/designs/ptat.sch
**.subckt ptat VDD GND IPTAT
*.iopin VDD
*.iopin GND
*.opin IPTAT
XM1 VP1 VP1 VDD VDD sky130_fd_pr__pfet_01v8 L=1 W=4 nf=1 ad=1.16 as=1.16 pd=8.58 ps=8.58 nrd=0.0725 nrs=0.0725 sa=0 sb=0 sd=0
+ mult=1 m=1
XM2 IPTAT VP1 VDD VDD sky130_fd_pr__pfet_01v8 L=1 W=4 nf=1 ad=1.16 as=1.16 pd=8.58 ps=8.58 nrd=0.0725 nrs=0.0725 sa=0 sb=0 sd=0
+ mult=1 m=1
XR1 VE1 IPTAT GND sky130_fd_pr__res_high_po_0p69 L=400 mult=1 m=1
x1 VDD VE1 VP1 VBase GND ota
XQ1 GND VBase VE1 sky130_fd_pr__pnp_05v5_W3p40L3p40 m=8 mult=8
XQ2 GND VBase IPTAT sky130_fd_pr__pnp_05v5_W3p40L3p40 m=1 mult=1
**.ends

* expanding   symbol:  ota.sym # of pins=5
** sym_path: /foss/designs/ota.sym
** sch_path: /foss/designs/ota.sch
.subckt ota VDD V2 V1 Vout GND
*.iopin VDD
*.iopin GND
*.ipin V2
*.ipin V1
*.opin Vout
XM1 net2 V1 net1 VDD sky130_fd_pr__pfet_01v8 L=1 W=8 nf=2 ad=1.16 as=2.32 pd=8.58 ps=17.16 nrd=0.03625 nrs=0.03625 sa=0 sb=0 sd=0
+ mult=1 m=1
XM3 net2 net2 GND GND sky130_fd_pr__nfet_01v8 L=1 W=4 nf=1 ad=1.16 as=1.16 pd=8.58 ps=8.58 nrd=0.0725 nrs=0.0725 sa=0 sb=0 sd=0
+ mult=1 m=1
XM4 Vout net2 GND GND sky130_fd_pr__nfet_01v8 L=1 W=4 nf=1 ad=1.16 as=1.16 pd=8.58 ps=8.58 nrd=0.0725 nrs=0.0725 sa=0 sb=0 sd=0
+ mult=1 m=1
XM2 Vout V2 net1 VDD sky130_fd_pr__pfet_01v8 L=1 W=8 nf=2 ad=1.16 as=2.32 pd=8.58 ps=17.16 nrd=0.03625 nrs=0.03625 sa=0 sb=0 sd=0
+ mult=1 m=1
XM5 net1 net1 VDD VDD sky130_fd_pr__pfet_01v8 L=2 W=4 nf=1 ad=1.16 as=1.16 pd=8.58 ps=8.58 nrd=0.0725 nrs=0.0725 sa=0 sb=0 sd=0
+ mult=1 m=1
**** begin user architecture code

**** end user architecture code
.ends

.end
